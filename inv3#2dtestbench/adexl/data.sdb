ADE simulation setup
Run mode: Single Run, Sweeps and Corners
Tests:
  lab6:inv3-testbench:1: lab6/inv3-testbench/schematic, simulator spectre
Global variables:
  beta = 2.5
  lambda = 50n
