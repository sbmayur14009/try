ADE simulation setup
Run mode: Single Run, Sweeps and Corners
Tests:
  lab6:inv1:1: lab6/inv1/schematic, simulator spectre
